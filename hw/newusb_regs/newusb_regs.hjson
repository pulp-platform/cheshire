// Copyright 2022 ETH Zurich and University of Bologna.
// Solderpad Hardware License, Version 0.51, see LICENSE for details.
// SPDX-License-Identifier: SHL-0.51
// Licensed under Solderpad Hardware License, Version 0.51, see LICENSE for details.
//
// Nicole Narr <narrn@student.ethz.ch>
// Christopher Reinwardt <creinwar@student.ethz.ch>
// Paul Scheffler <paulsc@iis.ee.ethz.ch>

{
  name: "newusb"
  clock_primary: "clk_i"
  bus_interfaces: [
    { protocol: "reg_iface", direction: "device" }
  ],
  regwidth: 32
  registers: [

    { name:     "HcRevision"
      desc:     "OHCI Revision Number Register"
      swaccess: "ro"
      hwaccess: "hrw"
      fields: [
        { bits:   "31:8"
          name:   "Reserved"
          resval: "0"
        }
        { bits:   "7:0"
          name:   "REV"
          desc:   "Ohci Revision"
          resval: "16"
        }
      ]
    }

    { name:     "HcControl"
      desc:     "HC Control Operating Mode Register"
      swaccess: "ro"
      hwaccess: "hrw"
      fields: [
        { bits:   "31:11"
          name:   "Reserved"
          resval: "0"
        }
        { bits:     "10"
          name:     "RWE"
          desc:     "RemoteWakeupEnable"
          swaccess: "rw"
          hwaccess: "hrw"
          resval:   "0"
          enum: [
            { value: "0", name: "disabled",   desc: "Remote wake-up disabled"  }
            { value: "1", name: "enabled",    desc: "Remote wake-up enabled"   }
          ]
        }
        { bits:     "9"
          name:     "RWC"
          desc:     "RemoteWakeupConnected"
          swaccess: "rw"
          hwaccess: "hrw"
          resval:   "0"
          enum: [
            { value: "0", name: "disconnected", desc: "Remote wake-up disconnected" }
            { value: "1", name: "connected",    desc: "Remote wake-up connected"    }
          ]
        }
        { bits:     "8"
          name:     "IR"
          desc:     "InterruptRouting. Tied to zero. SMIs are currently not implemented."
          swaccess: "rw"
          hwaccess: "hrw"
          resval:   "0"
        }
        { bits:     "7:6"
          name:     "HCFS"
          desc:     "HostControllerFunctionalState"
          swaccess: "rw"
          hwaccess: "hrw"
          resval:   "0"
          enum: [
            { value: "0", name: "reset",       desc: "USB reset"       }
            { value: "1", name: "resume",      desc: "USB resume"      }
            { value: "2", name: "operational", desc: "USB operational" }
            { value: "3", name: "suspend",     desc: "USB suspend"     }
          ]
        }
        { bits:     "5"
          name:     "BLE"
          desc:     "BulkListEnable"
          swaccess: "rw"
          hwaccess: "hrw"
          resval:   "0"
          enum: [
            { value: "0", name: "disabled", desc: "Disables processing of the bulk ED list" }
            { value: "1", name: "enabled",  desc: "Enables processing of the bulk ED list" }
          ]
        }
        { bits:     "4"
          name:     "CLE"
          desc:     "ControlListEnable"
          swaccess: "rw"
          hwaccess: "hrw"
          resval:   "0"
          enum: [
            { value: "0", name: "disabled", desc: "Disables processing of the control ED list" }
            { value: "1", name: "enabled",  desc: "Enables processing of the control ED list" }
          ]
        }
        { bits:     "3"
          name:     "IE"
          desc:     "IsochronousEnable"
          swaccess: "rw"
          hwaccess: "hrw"
          resval:   "0"
          enum: [
            { value: "0", name: "disabled", desc: "Disables processing of the isochronous EDs" }
            { value: "1", name: "enabled",  desc: "Enables processing of the isochronous EDs" }
          ]
        }
        { bits:     "2"
          name:     "PLE"
          desc:     "PeriodicListEnable"
          swaccess: "rw"
          hwaccess: "hrw"
          resval:   "0"
          enum: [
            { value: "0", name: "disabled", desc: "Periodic ED lists are not processed. Periodic list processing is disabled beginning with the next frame." }
            { value: "1", name: "enabled",  desc: "Enables processing of the periodic ED lists. Periodic list processing begins in the next frame."          }
          ]
        }
        { bits:     "1:0"
          name:     "CBSR"
          desc:     "ControlBulkServiceRatio"
          swaccess: "rw"
          hwaccess: "hrw"
          resval:   "0"
          enum: [
            { value: "0", name: "ratio1", desc: "1 control ED per bulk ED"  }
            { value: "1", name: "ratio2", desc: "2 control EDs per bulk ED" }
            { value: "2", name: "ratio3", desc: "3 control EDs per bulk ED" }
            { value: "3", name: "ratio4", desc: "4 control EDs per bulk ED" }
          ]
        }
      ]
    }

    { name:     "HcCommandStatus"
      desc:     "HC Command and Status Register"
      swaccess: "ro"
      hwaccess: "hrw"
      fields: [
        { bits:   "31:18"
          name:   "Reserved"
          resval: "0"
        }
        { bits:   "17:16"
          name:   "SOC"
          desc:   "SchedulingOverrunCount"
          resval: "0"
        }
        { bits:   "15:4"
          name:   "Reserved"
          resval: "0"
        }
        { bits:     "3"
          name:     "OCR"
          desc:     "OwnershipChangeRequest"
          swaccess: "rw"
          hwaccess: "hrw"
          resval:   "0"
          enum: [
            { value: "0", name: "not_owned", desc: "The HC driver doesn't own the HC." }
            { value: "1", name: "owned",     desc: "The HC driver owns the HC."        }
          ]
        }
        { bits:     "2"
          name:     "BLF"
          desc:     "BulkListFilled"
          swaccess: "rw"
          hwaccess: "hrw"
          resval:   "0"
          enum: [
            { value: "0", name: "not_filled", desc: "Not filled and not ready for bulk list processing." }
            { value: "1", name: "filled",     desc: "Filled and ready for bulk list processing"          }
          ]
        }
        { bits:     "1"
          name:     "CLF"
          desc:     "ControlListFilled"
          swaccess: "rw"
          hwaccess: "hrw"
          resval:   "0"
          enum: [
            { value: "0", name: "not_filled", desc: "Not filled and not ready for control list processing." }
            { value: "1", name: "filled",     desc: "Filled and ready for control list processing"          }
          ]
        }
        { bits:     "0"
          name:     "HCR"
          desc:     "HostControllerReset"
          swaccess: "rw"
          hwaccess: "hrw"
          resval:   "0"
          enum: [
            { value: "0", name: "no_effect",       desc: "No effect"                   }
            { value: "1", name: "software_reset",  desc: "Software reset of HC by HCD" }
          ]
        }
      ]
    }

    { name:     "HcInterruptStatus"
      desc:     "HC Interrupt and Status Register"
      swaccess: "ro"
      hwaccess: "hrw"
      fields: [
        { bits:   "31"
          name:   "Reserved"
          resval: "0"
        }
        { bits:     "30"
          name:     "OC"
          desc:     "OwnershipChange. Tied to zero. SMIs are currently not implemented."
          swaccess: "rw"
          hwaccess: "hrw"
          resval:   "0"
        }
        { bits:   "29:7"
          name:   "Reserved"
          resval: "0"
        }
        { bits:     "6"
          name:     "RHSC"
          desc:     "RootHubStatusChange"
          swaccess: "rw"
          hwaccess: "hrw"
          resval:   "0"
          enum: [
            { value: "0", name: "unchanged", desc: "Unchanged"                                           }
            { value: "1", name: "changed",   desc: "Changed HcRhStatus content or of any HcRhPortStatus" }
          ]
        }
        { bits:     "5"
          name:     "FNO"
          desc:     "FrameNumberOverflow"
          swaccess: "rw"
          hwaccess: "hrw"
          resval:   "0"
          enum: [
            { value: "0", name: "unchanged", desc: "Unchanged"                                         }
            { value: "1", name: "changed",   desc: "Changed MSb HcFmNUmber or updated HccaFrameNumber" }
          ]
        }
        { bits:     "4"
          name:     "UE"
          desc:     "UnrecoverableError"
          swaccess: "rw"
          hwaccess: "hrw"
          resval:   "0"
          enum: [
            { value: "0", name: "normal", desc: "Normal"                          }
            { value: "1", name: "error",  desc: "Error unrelated to USB detected" }
          ]
        }
        { bits:     "3"
          name:     "RD"
          desc:     "ResumeDetected"
          swaccess: "rw"
          hwaccess: "hrw"
          resval:   "0"
          enum: [
            { value: "0", name: "no_transition", desc: "No transition detected"                                          }
            { value: "1", name: "transition",    desc: "Transition detectd from no resume signaling to resume signaling" }
          ]
        }
        { bits:     "2"
          name:     "SF"
          desc:     "StartofFrame"
          swaccess: "rw"
          hwaccess: "hrw"
          resval:   "0"
          enum: [
            { value: "0", name: "frame_isnt_starting", desc: "No new frame is currently starting"                     }
            { value: "1", name: "frame_is_starting",   desc: "A new frame is starting or HccaFrameNumber was updated" }
          ]
        }
        { bits:     "1"
          name:     "WDH"
          desc:     "WritebackDoneHead"
          swaccess: "rw"
          hwaccess: "hrw"
          resval:   "0"
          enum: [
            { value: "0", name: "not_set", desc: "HccaDoneHead is not set." }
            { value: "1", name: "set",     desc: "HccaDoneHead is set."     }
          ]
        }
        { bits:     "0"
          name:     "SO"
          desc:     "SchedulingOverrun"
          swaccess: "rw"
          hwaccess: "hrw"
          resval:   "0"
          enum: [
            { value: "0", name: "no_effect", desc: "No effect"                                                         }
            { value: "1", name: "overrun",   desc: "USB schedule for current Frame overrun or updated HccaFrameNumber" }
          ]
        }
      ]
    }

    { name:     "HcInterruptEnable"
      desc:     "HC Interrupt Enable Register"
      swaccess: "ro"
      hwaccess: "hrw"
      fields: [
        { bits:     "31"
          name:     "MIE"
          desc:     "MasterInterruptEnable"
          swaccess: "rw"
          hwaccess: "hrw"
          resval:   "0"
          enum: [
            { value: "0", name: "no_effect",       desc: "No effect"                                                                                }
            { value: "1", name: "enable_all_gen",  desc: "Enable generation of all other interrupts according to set the bits in HcInterruptEnable" }
          ]
        }
        { bits:     "30"
          name:     "OC"
          desc:     "OwnershipChange"
          swaccess: "rw"
          hwaccess: "hrw"
          resval:   "0"
          enum: [
            { value: "0", name: "no_effect",   desc: "No effect"                                   }
            { value: "1", name: "enable_gen",  desc: "Enable OwnershipChange interrupt generation" }
          ]
        }
        { bits:   "29:7"
          name:   "Reserved"
          resval: "0"
        }
        { bits:     "6"
          name:     "RHCS"
          desc:     "RootHubStatusChange"
          swaccess: "rw"
          hwaccess: "hrw"
          resval:   "0"
          enum: [
            { value: "0", name: "no_effect",   desc: "No effect"                                       }
            { value: "1", name: "enable_gen",  desc: "Enable RootHubStatusChange interrupt generation" }
          ]
        }
        { bits:     "5"
          name:     "FNO"
          desc:     "FrameNumberOverflow"
          swaccess: "rw"
          hwaccess: "hrw"
          resval:   "0"
          enum: [
            { value: "0", name: "no_effect",   desc: "No effect"                                       }
            { value: "1", name: "enable_gen",  desc: "Enable FrameNumberOverflow interrupt generation" }
          ]
        }
        { bits:     "4"
          name:     "UE"
          desc:     "UnrecoverableError"
          swaccess: "rw"
          hwaccess: "hrw"
          resval:   "0"
          enum: [
            { value: "0", name: "no_effect",   desc: "No effect"                                      }
            { value: "1", name: "enable_gen",  desc: "Enable UnrecoverableError interrupt generation" }
          ]
        }
        { bits:     "3"
          name:     "RD"
          desc:     "ResumeDetected"
          swaccess: "rw"
          hwaccess: "hrw"
          resval:   "0"
          enum: [
            { value: "0", name: "no_effect",   desc: "No effect"                                  }
            { value: "1", name: "enable_gen",  desc: "Enable ResumeDetected interrupt generation" }
          ]
        }
        { bits:     "2"
          name:     "SF"
          desc:     "StartofFrame"
          swaccess: "rw"
          hwaccess: "hrw"
          resval:   "0"
          enum: [
            { value: "0", name: "no_effect",   desc: "No effect"                                }
            { value: "1", name: "enable_gen",  desc: "Enable StartofFrame interrupt generation" }
          ]
        }
        { bits:     "1"
          name:     "WDH"
          desc:     "WritebackDoneHead"
          swaccess: "rw"
          hwaccess: "hrw"
          resval:   "0"
          enum: [
            { value: "0", name: "no_effect",   desc: "No effect"                                     }
            { value: "1", name: "enable_gen",  desc: "Enable WritebackDoneHead interrupt generation" }
          ]
        }
        { bits:     "0"
          name:     "SO"
          desc:     "SchedulingOverrun"
          swaccess: "rw"
          hwaccess: "hrw"
          resval:   "0"
          enum: [
            { value: "0", name: "no_effect",   desc: "No effect"                                     }
            { value: "1", name: "enable_gen",  desc: "Enable SchedulingOverrun interrupt generation" }
          ]
        }
      ]
    }

    { name:     "HcInterruptDisable"
      desc:     "HC Interrupt Disable Register"
      swaccess: "ro"
      hwaccess: "hrw"
      fields: [
        { bits:     "31"
          name:     "MIE"
          desc:     "MasterInterruptDisable"
          swaccess: "rw"
          hwaccess: "hrw"
          resval:   "0"
          enum: [
            { value: "0", name: "no_effect",        desc: "No effect"                                                                                  }
            { value: "1", name: "disable_all_gen",  desc: "Disable generation of all other interrupts according to set the bits in HcInterruptDisable" }
          ]
        }
        { bits:     "30"
          name:     "OC"
          desc:     "OwnershipChange"
          swaccess: "rw"
          hwaccess: "hrw"
          resval:   "0"
          enum: [
            { value: "0", name: "no_effect",    desc: "No effect"                                    }
            { value: "1", name: "disable_gen",  desc: "Disable OwnershipChange interrupt generation" }
          ]
        }
        { bits:   "29:7"
          name:   "Reserved"
          resval: "0"
        }
        { bits:     "6"
          name:     "RHCS"
          desc:     "RootHubStatusChange"
          swaccess: "rw"
          hwaccess: "hrw"
          resval:   "0"
          enum: [
            { value: "0", name: "no_effect",    desc: "No effect"                                        }
            { value: "1", name: "disable_gen",  desc: "Disable RootHubStatusChange interrupt generation" }
          ]
        }
        { bits:     "5"
          name:     "FNO"
          desc:     "FrameNumberOverflow"
          swaccess: "rw"
          hwaccess: "hrw"
          resval:   "0"
          enum: [
            { value: "0", name: "no_effect",    desc: "No effect"                                        }
            { value: "1", name: "disable_gen",  desc: "Disable FrameNumberOverflow interrupt generation" }
          ]
        }
        { bits:     "4"
          name:     "UE"
          desc:     "UnrecoverableError"
          swaccess: "rw"
          hwaccess: "hrw"
          resval:   "0"
          enum: [
            { value: "0", name: "no_effect",    desc: "No effect"                                       }
            { value: "1", name: "disable_gen",  desc: "Disable UnrecoverableError interrupt generation" }
          ]
        }
        { bits:     "3"
          name:     "RD"
          desc:     "Resume Detect"
          swaccess: "rw"
          hwaccess: "hrw"
          resval:   "0"
          enum: [
            { value: "0", name: "no_effect",    desc: "No effect"                                   }
            { value: "1", name: "disable_gen",  desc: "Disable ResumeDetected interrupt generation" }
          ]
        }
        { bits:     "2"
          name:     "SF"
          desc:     "StartofFrame"
          swaccess: "rw"
          hwaccess: "hrw"
          resval:   "0"
          enum: [
            { value: "0", name: "no_effect",    desc: "No effect"                                 }
            { value: "1", name: "disable_gen",  desc: "Disable StartofFrame interrupt generation" }
          ]
        }
        { bits:     "1"
          name:     "WDH"
          desc:     "WritebackDoneHead"
          swaccess: "rw"
          hwaccess: "hrw"
          resval:   "0"
          enum: [
            { value: "0", name: "no_effect",    desc: "No effect"                                      }
            { value: "1", name: "disable_gen",  desc: "Disable WritebackDoneHead interrupt generation" }
          ]
        }
        { bits:     "0"
          name:     "SO"
          desc:     "SchedulingOverrun"
          swaccess: "rw"
          hwaccess: "hrw"
          resval:   "0"
          enum: [
            { value: "0", name: "no_effect",    desc: "No effect"                                      }
            { value: "1", name: "disable_gen",  desc: "Disable SchedulingOverrun interrupt generation" }
          ]
        }
      ]
    }

    { name:     "HcHCAA"
      desc:     "HC HCAA Address Register"
      swaccess: "ro"
      hwaccess: "hrw"
      fields: [
        { bits:     "31:8"
          name:     "HCCA"
          desc:     "HostControllerCommunicationArea"
          swaccess: "rw"
          hwaccess: "hrw"
          resval:   "0"
        }
        { bits:     "7:0"
          name:     "0"
          swaccess: "rw"
          hwaccess: "hrw"
          resval:   "0"
        }
      ]
    }

    { name:     "HcPeriodCurrentED"
      desc:     "HC Current Periodic Register"
      swaccess: "ro"
      hwaccess: "hrw"
      fields: [
        { bits:     "31:4"
          name:     "PCED"
          desc:     "PeriodCurrentED"
          resval:   "0"
        }
        { bits:     "3:0"
          name:     "0"
          resval:   "0"
        }
      ]
    }

    { name:     "HcControlHeadED"
      desc:     "HC Head Control Register"
      swaccess: "ro"
      hwaccess: "hrw"
      fields: [
        { bits:     "31:4"
          name:     "CHED"
          desc:     "ControlHeadED"
          swaccess: "rw"
          hwaccess: "hrw"
          resval:   "0"
        }
        { bits:     "3:0"
          name:     "0"
          swaccess: "rw"
          hwaccess: "hrw"
          resval:   "0"
        }
      ]
    }

    { name:     "HcControlCurrentED"
      desc:     "HC Current Control Register"
      swaccess: "ro"
      hwaccess: "hrw"
      fields: [
        { bits:     "31:4"
          name:     "CCED"
          desc:     "ControlCurrentED"
          swaccess: "rw"
          hwaccess: "hrw"
          resval:   "0"
        }
        { bits:     "3:0"
          name:     "0"
          swaccess: "rw"
          hwaccess: "hrw"
          resval:   "0"
        }
      ]
    }

    { name:     "HcBulkHeadED"
      desc:     "HC Head Bulk Register"
      swaccess: "ro"
      hwaccess: "hrw"
      fields: [
        { bits:     "31:4"
          name:     "BHED"
          desc:     "BulkHeadED"
          swaccess: "rw"
          hwaccess: "hrw"
          resval:   "0"
        }
        { bits:     "3:0"
          name:     "0"
          swaccess: "rw"
          hwaccess: "hrw"
          resval:   "0"
        }
      ]
    }

    { name:     "HcBulkCurrentED"
      desc:     "HC Current Bulk Register"
      swaccess: "ro"
      hwaccess: "hrw"
      fields: [
        { bits:     "31:4"
          name:     "BCED"
          desc:     "BulkCurrentED"
          swaccess: "rw"
          hwaccess: "hrw"
          resval:   "0"
        }
        { bits:     "3:0"
          name:     "0"
          swaccess: "rw"
          hwaccess: "hrw"
          resval:   "0"
        }
      ]
    }


    { name:     "HcDoneHead"
      desc:     "HC Head Done Register"
      swaccess: "ro"
      hwaccess: "hrw"
      fields: [
        { bits:     "31:4"
          name:     "DH"
          desc:     "DoneHead"
          resval:   "0"
        }
        { bits:     "3:0"
          name:     "0"
          resval:   "0"
        }
      ]
    }

    { name:     "HcFmInterval"
      desc:     "HC Frame Interval Register"
      swaccess: "ro"
      hwaccess: "hrw"
      fields: [
        { bits:     "31"
          name:     "FIT"
          desc:     "FrameInvervalToggle"
          swaccess: "rw"
          hwaccess: "hrw"
          resval:   "0"
        }
        { bits:     "30:16"
          name:     "FSMPS"
          desc:     "FSLargestDataPacket"
          swaccess: "rw"
          hwaccess: "hrw"
        }
        { bits:   "15:14"
          name:   "Reserved"
          resval: "0"
        }
        { bits:     "13:0"
          name:     "FI"
          desc:     "FrameInverval"
          swaccess: "rw"
          hwaccess: "hrw"
          resval:   "11999"
        }
      ]
    }

    { name:     "HcFmRemaining"
      desc:     "HC Frame Remaining Register"
      swaccess: "ro"
      hwaccess: "hrw"
      fields: [
        { bits:     "31"
          name:     "FRT"
          desc:     "FrameRemainingToggle"
          resval:   "0"
        }
        { bits:   "30:14"
          name:   "Reserved"
          resval: "0"
        }
        { bits:     "13:0"
          name:     "FR"
          desc:     "FrameRemaining"
          resval:   "0"
        }
      ]
    }

    { name:     "HcFmNumber"
      desc:     "HC Frame Number Register"
      swaccess: "ro"
      hwaccess: "hrw"
      fields: [
        { bits:   "31:16"
          name:   "Reserved"
          resval: "0"
        }
        { bits:     "15:0"
          name:     "FN"
          desc:     "FrameNumber"
          resval:   "0"
        }
      ]
    }

    { name:     "HcPeriodicStart"
      desc:     "HC Periodic Start Register"
      swaccess: "ro"
      hwaccess: "hrw"
      fields: [
        { bits:   "31:14"
          name:   "Reserved"
          resval: "0"
        }
        { bits:     "13:0"
          name:     "PS"
          desc:     "PeriodicStart"
          swaccess: "rw"
          hwaccess: "hrw"
          resval:   "0"
        }
      ]
    }

    { name:     "HcLSThreshold"
      desc:     "HC Low-Speed Threshold Register"
      swaccess: "ro"
      hwaccess: "hrw"
      fields: [
        { bits:   "31:12"
          name:   "Reserved"
          resval: "0"
        }
        { bits:     "11:0"
          name:     "LST"
          desc:     "LSThreshold"
          swaccess: "rw"
          hwaccess: "hrw"
          resval:   "1576"
        }
      ]
    }

    { name:     "HcRhDescriptorA"
      desc:     "HC Root Hub A Register "
      swaccess: "ro"
      hwaccess: "hrw"
      fields: [
        { bits:     "31:24"
          name:     "POTPGT"
          desc:     "PowerOnToPowerGoodTime"
          swaccess: "rw"
          hwaccess: "hrw"
          resval:   "10"
        }
        { bits:   "23:13"
          name:   "Reserved"
          resval: "0"
        }
        { bits:     "12"
          name:     "NOCP"
          desc:     "NoOverCurrentProtection"
          swaccess: "rw"
          hwaccess: "hrw"
          resval:   "1"
          enum: [
            { value: "0", name: "protected",     desc: "Over-current protection supported"   }
            { value: "1", name: "unprotected",   desc: "Over-current protection unsupported" }
          ]
        }
        { bits:     "11"
          name:     "OCPM"
          desc:     "OverCurrentProtectionMode, not relevant if NOCP=1"
          swaccess: "rw"
          hwaccess: "hrw"
          resval:   "0"
          enum: [
            { value: "0", name: "global_report",        desc: "Over-current reported globally"          }
            { value: "1", name: "single_port_report",   desc: "Over-current reported on per port basis" }
          ]
        }
        { bits:     "10"
          name:     "DT"
          desc:     "DeviceType"
          resval:   "0"
        }
        { bits:     "9"
          name:     "PSM"
          desc:     "PowerSwitchingMode"
          swaccess: "rw"
          hwaccess: "hrw"
          resval:   "0"
          enum: [
            { value: "0", name: "global_power",            desc: "All ports powered globally at the same time" }
            { value: "1", name: "individual_port_power",   desc: "Individual port power"                       }
          ]
        }
        { bits:     "8"
          name:     "NPS"
          desc:     "NoPowerSwitching"
          swaccess: "rw"
          hwaccess: "hrw"
          resval:   "1"
          enum: [
            { value: "0", name: "power_switching",      desc: "Power switching enabled for ports"                       }
            { value: "1", name: "no_power_switching",   desc: "Power switching disabled for ports. Ports are always ON" }
          ]
        }
        { bits:     "7:0"
          name:     "NDP"
          desc:     "NumberDownstreamPorts"
          resval:   "8"
        }
      ]
    }

    { name:     "HcRhDescriptorB"
      desc:     "HC Root Hub B Register "
      swaccess: "ro"
      hwaccess: "hrw"
      fields: [
        { bits:     "31:16"
          name:     "PPCM"
          desc:     "PortPowerControlMask, unused if PowerSwitchingMode=0"
          swaccess: "rw"
          hwaccess: "hrw"
          resval:   "0"
        }
        { bits:     "15:0"
          name:     "DR"
          desc:     "DeviceRemovable, port1 removable if bit1=0"
          swaccess: "rw"
          hwaccess: "hrw"
          resval:   "0"
        }
      ]
    }

    { name:     "HcRhStatus"
      desc:     "HC Root Hub Status Register "
      swaccess: "ro"
      hwaccess: "hrw"
      fields: [
        { bits:     "31"
          name:     "CRWE"
          desc:     "ClearRemoteWakeupEnable"
          swaccess: "wo"
          hwaccess: "hrw"
        }
        { bits:     "30:18"
          name:     "Reserved"
          resval:   "0"
        }
        { bits:     "17"
          name:     "OCIC"
          desc:     "OverCurrentIndicatorChange"
          swaccess: "rw"
          hwaccess: "hrw"
          resval:   "0"
        }
        { bits:     "16"
          name:     "LPSC"
          desc:     "LocalPowerStatusChange"
          swaccess: "rw"
          hwaccess: "hrw"
          resval:   "0"
        }
        { bits:     "15"
          name:     "DRWE"
          desc:     "DeviceRemoteWakeupEnable"
          swaccess: "rw"
          hwaccess: "hrw"
          resval:   "0"
        }
        { bits:     "14:2"
          name:     "Reserved"
          resval:   "0"
        }
        { bits:     "1"
          name:     "OCI"
          desc:     "OverCurrentIndicator"
          resval:   "0"
        }
        { bits:     "0"
          name:     "LPS"
          desc:     "LocalPowerStatus"
          swaccess: "rw"
          hwaccess: "hrw"
          resval:   "0"
        }
      ]
    }

    { name:     "HcRhPortStatus[1]"
      desc:     "HC Port 1 Status and Control Register"
      swaccess: "ro"
      hwaccess: "hrw"
      fields: [
        { bits:     "31:21"
          name:     "Reserved"
          resval:   "0"
        }
        { bits:     "20"
          name:     "PRSC"
          desc:     "PortResetStatusChange"
          swaccess: "rw"
          hwaccess: "hrw"
          resval:   "0"
        }
        { bits:     "19"
          name:     "OCIC"
          desc:     "PortOverCurrentIndicatorChange"
          swaccess: "rw"
          hwaccess: "hrw"
          resval:   "0"
        }
        { bits:     "18"
          name:     "PSSC"
          desc:     "PortEnableStatusChange"
          swaccess: "rw"
          hwaccess: "hrw"
          resval:   "0"
        }
        { bits:     "17"
          name:     "PESC"
          desc:     "LocalPowerStatusChange"
          swaccess: "rw"
          hwaccess: "hrw"
          resval:   "0"
        }
        { bits:     "16"
          name:     "CSC"
          desc:     "ConnectStatusChange"
          swaccess: "rw"
          hwaccess: "hrw"
          resval:   "0"
        }
        { bits:     "15:10"
          name:     "Reserved"
          resval:   "0"
        }
        { bits:     "9"
          name:     "LSDA"
          desc:     "LowSpeedDeviceAttached"
          swaccess: "rw"
          hwaccess: "hrw"
          resval:   "0"
        }
        { bits:     "8"
          name:     "PPS"
          desc:     "PortPowerStatus"
          swaccess: "rw"
          hwaccess: "hrw"
          resval:   "0"
        }
        { bits:     "7:5"
          name:     "Reserved"
          resval:   "0"
        }
        { bits:     "4"
          name:     "PRS"
          desc:     "PortResetStatus"
          swaccess: "rw"
          hwaccess: "hrw"
          resval:   "0"
        }
        { bits:     "3"
          name:     "POCI"
          desc:     "PortOverCurrentIndicator"
          swaccess: "rw"
          hwaccess: "hrw"
          resval:   "0"
        }
        { bits:     "2"
          name:     "PSS"
          desc:     "PortSuspendStatus"
          swaccess: "rw"
          hwaccess: "hrw"
          resval:   "0"
        }
        { bits:     "1"
          name:     "PES"
          desc:     "PortEnableStatus"
          swaccess: "rw"
          hwaccess: "hrw"
          resval:   "0"
        }
        { bits:     "0"
          name:     "CCS"
          desc:     "CurrentConnectStatus"
          swaccess: "rw"
          hwaccess: "hrw"
          resval:   "0"
        }
      ]
    }

    { name:     "HcRhPortStatus[2]"
      desc:     "HC Port 2 Status and Control Register"
      swaccess: "ro"
      hwaccess: "hrw"
      fields: [
        { bits:     "31:21"
          name:     "Reserved"
          resval:   "0"
        }
        { bits:     "20"
          name:     "PRSC"
          desc:     "PortResetStatusChange"
          swaccess: "rw"
          hwaccess: "hrw"
          resval:   "0"
        }
        { bits:     "19"
          name:     "OCIC"
          desc:     "PortOverCurrentIndicatorChange"
          swaccess: "rw"
          hwaccess: "hrw"
          resval:   "0"
        }
        { bits:     "18"
          name:     "PSSC"
          desc:     "PortEnableStatusChange"
          swaccess: "rw"
          hwaccess: "hrw"
          resval:   "0"
        }
        { bits:     "17"
          name:     "PESC"
          desc:     "LocalPowerStatusChange"
          swaccess: "rw"
          hwaccess: "hrw"
          resval:   "0"
        }
        { bits:     "16"
          name:     "CSC"
          desc:     "ConnectStatusChange"
          swaccess: "rw"
          hwaccess: "hrw"
          resval:   "0"
        }
        { bits:     "15:10"
          name:     "Reserved"
          resval:   "0"
        }
        { bits:     "9"
          name:     "LSDA"
          desc:     "LowSpeedDeviceAttached"
          swaccess: "rw"
          hwaccess: "hrw"
          resval:   "0"
        }
        { bits:     "8"
          name:     "PPS"
          desc:     "PortPowerStatus"
          swaccess: "rw"
          hwaccess: "hrw"
          resval:   "0"
        }
        { bits:     "7:5"
          name:     "Reserved"
          resval:   "0"
        }
        { bits:     "4"
          name:     "PRS"
          desc:     "PortResetStatus"
          swaccess: "rw"
          hwaccess: "hrw"
          resval:   "0"
        }
        { bits:     "3"
          name:     "POCI"
          desc:     "PortOverCurrentIndicator"
          swaccess: "rw"
          hwaccess: "hrw"
          resval:   "0"
        }
        { bits:     "2"
          name:     "PSS"
          desc:     "PortSuspendStatus"
          swaccess: "rw"
          hwaccess: "hrw"
          resval:   "0"
        }
        { bits:     "1"
          name:     "PES"
          desc:     "PortEnableStatus"
          swaccess: "rw"
          hwaccess: "hrw"
          resval:   "0"
        }
        { bits:     "0"
          name:     "CCS"
          desc:     "CurrentConnectStatus"
          swaccess: "rw"
          hwaccess: "hrw"
          resval:   "0"
        }
      ]
    }

    { name:     "HcRhPortStatus[3]"
      desc:     "HC Port 3 Status and Control Register"
      swaccess: "ro"
      hwaccess: "hrw"
      fields: [
        { bits:     "31:21"
          name:     "Reserved"
          resval:   "0"
        }
        { bits:     "20"
          name:     "PRSC"
          desc:     "PortResetStatusChange"
          swaccess: "rw"
          hwaccess: "hrw"
          resval:   "0"
        }
        { bits:     "19"
          name:     "OCIC"
          desc:     "PortOverCurrentIndicatorChange"
          swaccess: "rw"
          hwaccess: "hrw"
          resval:   "0"
        }
        { bits:     "18"
          name:     "PSSC"
          desc:     "PortEnableStatusChange"
          swaccess: "rw"
          hwaccess: "hrw"
          resval:   "0"
        }
        { bits:     "17"
          name:     "PESC"
          desc:     "LocalPowerStatusChange"
          swaccess: "rw"
          hwaccess: "hrw"
          resval:   "0"
        }
        { bits:     "16"
          name:     "CSC"
          desc:     "ConnectStatusChange"
          swaccess: "rw"
          hwaccess: "hrw"
          resval:   "0"
        }
        { bits:     "15:10"
          name:     "Reserved"
          resval:   "0"
        }
        { bits:     "9"
          name:     "LSDA"
          desc:     "LowSpeedDeviceAttached"
          swaccess: "rw"
          hwaccess: "hrw"
          resval:   "0"
        }
        { bits:     "8"
          name:     "PPS"
          desc:     "PortPowerStatus"
          swaccess: "rw"
          hwaccess: "hrw"
          resval:   "0"
        }
        { bits:     "7:5"
          name:     "Reserved"
          resval:   "0"
        }
        { bits:     "4"
          name:     "PRS"
          desc:     "PortResetStatus"
          swaccess: "rw"
          hwaccess: "hrw"
          resval:   "0"
        }
        { bits:     "3"
          name:     "POCI"
          desc:     "PortOverCurrentIndicator"
          swaccess: "rw"
          hwaccess: "hrw"
          resval:   "0"
        }
        { bits:     "2"
          name:     "PSS"
          desc:     "PortSuspendStatus"
          swaccess: "rw"
          hwaccess: "hrw"
          resval:   "0"
        }
        { bits:     "1"
          name:     "PES"
          desc:     "PortEnableStatus"
          swaccess: "rw"
          hwaccess: "hrw"
          resval:   "0"
        }
        { bits:     "0"
          name:     "CCS"
          desc:     "CurrentConnectStatus"
          swaccess: "rw"
          hwaccess: "hrw"
          resval:   "0"
        }
      ]
    }

    { name:     "HcRhPortStatus[4]"
      desc:     "HC Port 4 Status and Control Register"
      swaccess: "ro"
      hwaccess: "hrw"
      fields: [
        { bits:     "31:21"
          name:     "Reserved"
          resval:   "0"
        }
        { bits:     "20"
          name:     "PRSC"
          desc:     "PortResetStatusChange"
          swaccess: "rw"
          hwaccess: "hrw"
          resval:   "0"
        }
        { bits:     "19"
          name:     "OCIC"
          desc:     "PortOverCurrentIndicatorChange"
          swaccess: "rw"
          hwaccess: "hrw"
          resval:   "0"
        }
        { bits:     "18"
          name:     "PSSC"
          desc:     "PortEnableStatusChange"
          swaccess: "rw"
          hwaccess: "hrw"
          resval:   "0"
        }
        { bits:     "17"
          name:     "PESC"
          desc:     "LocalPowerStatusChange"
          swaccess: "rw"
          hwaccess: "hrw"
          resval:   "0"
        }
        { bits:     "16"
          name:     "CSC"
          desc:     "ConnectStatusChange"
          swaccess: "rw"
          hwaccess: "hrw"
          resval:   "0"
        }
        { bits:     "15:10"
          name:     "Reserved"
          resval:   "0"
        }
        { bits:     "9"
          name:     "LSDA"
          desc:     "LowSpeedDeviceAttached"
          swaccess: "rw"
          hwaccess: "hrw"
          resval:   "0"
        }
        { bits:     "8"
          name:     "PPS"
          desc:     "PortPowerStatus"
          swaccess: "rw"
          hwaccess: "hrw"
          resval:   "0"
        }
        { bits:     "7:5"
          name:     "Reserved"
          resval:   "0"
        }
        { bits:     "4"
          name:     "PRS"
          desc:     "PortResetStatus"
          swaccess: "rw"
          hwaccess: "hrw"
          resval:   "0"
        }
        { bits:     "3"
          name:     "POCI"
          desc:     "PortOverCurrentIndicator"
          swaccess: "rw"
          hwaccess: "hrw"
          resval:   "0"
        }
        { bits:     "2"
          name:     "PSS"
          desc:     "PortSuspendStatus"
          swaccess: "rw"
          hwaccess: "hrw"
          resval:   "0"
        }
        { bits:     "1"
          name:     "PES"
          desc:     "PortEnableStatus"
          swaccess: "rw"
          hwaccess: "hrw"
          resval:   "0"
        }
        { bits:     "0"
          name:     "CCS"
          desc:     "CurrentConnectStatus"
          swaccess: "rw"
          hwaccess: "hrw"
          resval:   "0"
        }
      ]
    }

    { name:     "HcRhPortStatus[5]"
      desc:     "HC Port 5 Status and Control Register"
      swaccess: "ro"
      hwaccess: "hrw"
      fields: [
        { bits:     "31:21"
          name:     "Reserved"
          resval:   "0"
        }
        { bits:     "20"
          name:     "PRSC"
          desc:     "PortResetStatusChange"
          swaccess: "rw"
          hwaccess: "hrw"
          resval:   "0"
        }
        { bits:     "19"
          name:     "OCIC"
          desc:     "PortOverCurrentIndicatorChange"
          swaccess: "rw"
          hwaccess: "hrw"
          resval:   "0"
        }
        { bits:     "18"
          name:     "PSSC"
          desc:     "PortEnableStatusChange"
          swaccess: "rw"
          hwaccess: "hrw"
          resval:   "0"
        }
        { bits:     "17"
          name:     "PESC"
          desc:     "LocalPowerStatusChange"
          swaccess: "rw"
          hwaccess: "hrw"
          resval:   "0"
        }
        { bits:     "16"
          name:     "CSC"
          desc:     "ConnectStatusChange"
          swaccess: "rw"
          hwaccess: "hrw"
          resval:   "0"
        }
        { bits:     "15:10"
          name:     "Reserved"
          resval:   "0"
        }
        { bits:     "9"
          name:     "LSDA"
          desc:     "LowSpeedDeviceAttached"
          swaccess: "rw"
          hwaccess: "hrw"
          resval:   "0"
        }
        { bits:     "8"
          name:     "PPS"
          desc:     "PortPowerStatus"
          swaccess: "rw"
          hwaccess: "hrw"
          resval:   "0"
        }
        { bits:     "7:5"
          name:     "Reserved"
          resval:   "0"
        }
        { bits:     "4"
          name:     "PRS"
          desc:     "PortResetStatus"
          swaccess: "rw"
          hwaccess: "hrw"
          resval:   "0"
        }
        { bits:     "3"
          name:     "POCI"
          desc:     "PortOverCurrentIndicator"
          swaccess: "rw"
          hwaccess: "hrw"
          resval:   "0"
        }
        { bits:     "2"
          name:     "PSS"
          desc:     "PortSuspendStatus"
          swaccess: "rw"
          hwaccess: "hrw"
          resval:   "0"
        }
        { bits:     "1"
          name:     "PES"
          desc:     "PortEnableStatus"
          swaccess: "rw"
          hwaccess: "hrw"
          resval:   "0"
        }
        { bits:     "0"
          name:     "CCS"
          desc:     "CurrentConnectStatus"
          swaccess: "rw"
          hwaccess: "hrw"
          resval:   "0"
        }
      ]
    }

    { name:     "HcRhPortStatus[6]"
      desc:     "HC Port 6 Status and Control Register"
      swaccess: "ro"
      hwaccess: "hrw"
      fields: [
        { bits:     "31:21"
          name:     "Reserved"
          resval:   "0"
        }
        { bits:     "20"
          name:     "PRSC"
          desc:     "PortResetStatusChange"
          swaccess: "rw"
          hwaccess: "hrw"
          resval:   "0"
        }
        { bits:     "19"
          name:     "OCIC"
          desc:     "PortOverCurrentIndicatorChange"
          swaccess: "rw"
          hwaccess: "hrw"
          resval:   "0"
        }
        { bits:     "18"
          name:     "PSSC"
          desc:     "PortEnableStatusChange"
          swaccess: "rw"
          hwaccess: "hrw"
          resval:   "0"
        }
        { bits:     "17"
          name:     "PESC"
          desc:     "LocalPowerStatusChange"
          swaccess: "rw"
          hwaccess: "hrw"
          resval:   "0"
        }
        { bits:     "16"
          name:     "CSC"
          desc:     "ConnectStatusChange"
          swaccess: "rw"
          hwaccess: "hrw"
          resval:   "0"
        }
        { bits:     "15:10"
          name:     "Reserved"
          resval:   "0"
        }
        { bits:     "9"
          name:     "LSDA"
          desc:     "LowSpeedDeviceAttached"
          swaccess: "rw"
          hwaccess: "hrw"
          resval:   "0"
        }
        { bits:     "8"
          name:     "PPS"
          desc:     "PortPowerStatus"
          swaccess: "rw"
          hwaccess: "hrw"
          resval:   "0"
        }
        { bits:     "7:5"
          name:     "Reserved"
          resval:   "0"
        }
        { bits:     "4"
          name:     "PRS"
          desc:     "PortResetStatus"
          swaccess: "rw"
          hwaccess: "hrw"
          resval:   "0"
        }
        { bits:     "3"
          name:     "POCI"
          desc:     "PortOverCurrentIndicator"
          swaccess: "rw"
          hwaccess: "hrw"
          resval:   "0"
        }
        { bits:     "2"
          name:     "PSS"
          desc:     "PortSuspendStatus"
          swaccess: "rw"
          hwaccess: "hrw"
          resval:   "0"
        }
        { bits:     "1"
          name:     "PES"
          desc:     "PortEnableStatus"
          swaccess: "rw"
          hwaccess: "hrw"
          resval:   "0"
        }
        { bits:     "0"
          name:     "CCS"
          desc:     "CurrentConnectStatus"
          swaccess: "rw"
          hwaccess: "hrw"
          resval:   "0"
        }
      ]
    }

    { name:     "HcRhPortStatus[7]"
      desc:     "HC Port 7 Status and Control Register"
      swaccess: "ro"
      hwaccess: "hrw"
      fields: [
        { bits:     "31:21"
          name:     "Reserved"
          resval:   "0"
        }
        { bits:     "20"
          name:     "PRSC"
          desc:     "PortResetStatusChange"
          swaccess: "rw"
          hwaccess: "hrw"
          resval:   "0"
        }
        { bits:     "19"
          name:     "OCIC"
          desc:     "PortOverCurrentIndicatorChange"
          swaccess: "rw"
          hwaccess: "hrw"
          resval:   "0"
        }
        { bits:     "18"
          name:     "PSSC"
          desc:     "PortEnableStatusChange"
          swaccess: "rw"
          hwaccess: "hrw"
          resval:   "0"
        }
        { bits:     "17"
          name:     "PESC"
          desc:     "LocalPowerStatusChange"
          swaccess: "rw"
          hwaccess: "hrw"
          resval:   "0"
        }
        { bits:     "16"
          name:     "CSC"
          desc:     "ConnectStatusChange"
          swaccess: "rw"
          hwaccess: "hrw"
          resval:   "0"
        }
        { bits:     "15:10"
          name:     "Reserved"
          resval:   "0"
        }
        { bits:     "9"
          name:     "LSDA"
          desc:     "LowSpeedDeviceAttached"
          swaccess: "rw"
          hwaccess: "hrw"
          resval:   "0"
        }
        { bits:     "8"
          name:     "PPS"
          desc:     "PortPowerStatus"
          swaccess: "rw"
          hwaccess: "hrw"
          resval:   "0"
        }
        { bits:     "7:5"
          name:     "Reserved"
          resval:   "0"
        }
        { bits:     "4"
          name:     "PRS"
          desc:     "PortResetStatus"
          swaccess: "rw"
          hwaccess: "hrw"
          resval:   "0"
        }
        { bits:     "3"
          name:     "POCI"
          desc:     "PortOverCurrentIndicator"
          swaccess: "rw"
          hwaccess: "hrw"
          resval:   "0"
        }
        { bits:     "2"
          name:     "PSS"
          desc:     "PortSuspendStatus"
          swaccess: "rw"
          hwaccess: "hrw"
          resval:   "0"
        }
        { bits:     "1"
          name:     "PES"
          desc:     "PortEnableStatus"
          swaccess: "rw"
          hwaccess: "hrw"
          resval:   "0"
        }
        { bits:     "0"
          name:     "CCS"
          desc:     "CurrentConnectStatus"
          swaccess: "rw"
          hwaccess: "hrw"
          resval:   "0"
        }
      ]
    }

    { name:     "HcRhPortStatus[8]"
      desc:     "HC Port 8 Status and Control Register"
      swaccess: "ro"
      hwaccess: "hrw"
      fields: [
        { bits:     "31:21"
          name:     "Reserved"
          resval:   "0"
        }
        { bits:     "20"
          name:     "PRSC"
          desc:     "PortResetStatusChange"
          swaccess: "rw"
          hwaccess: "hrw"
          resval:   "0"
        }
        { bits:     "19"
          name:     "OCIC"
          desc:     "PortOverCurrentIndicatorChange"
          swaccess: "rw"
          hwaccess: "hrw"
          resval:   "0"
        }
        { bits:     "18"
          name:     "PSSC"
          desc:     "PortEnableStatusChange"
          swaccess: "rw"
          hwaccess: "hrw"
          resval:   "0"
        }
        { bits:     "17"
          name:     "PESC"
          desc:     "LocalPowerStatusChange"
          swaccess: "rw"
          hwaccess: "hrw"
          resval:   "0"
        }
        { bits:     "16"
          name:     "CSC"
          desc:     "ConnectStatusChange"
          swaccess: "rw"
          hwaccess: "hrw"
          resval:   "0"
        }
        { bits:     "15:10"
          name:     "Reserved"
          resval:   "0"
        }
        { bits:     "9"
          name:     "LSDA"
          desc:     "LowSpeedDeviceAttached"
          swaccess: "rw"
          hwaccess: "hrw"
          resval:   "0"
        }
        { bits:     "8"
          name:     "PPS"
          desc:     "PortPowerStatus"
          swaccess: "rw"
          hwaccess: "hrw"
          resval:   "0"
        }
        { bits:     "7:5"
          name:     "Reserved"
          resval:   "0"
        }
        { bits:     "4"
          name:     "PRS"
          desc:     "PortResetStatus"
          swaccess: "rw"
          hwaccess: "hrw"
          resval:   "0"
        }
        { bits:     "3"
          name:     "POCI"
          desc:     "PortOverCurrentIndicator"
          swaccess: "rw"
          hwaccess: "hrw"
          resval:   "0"
        }
        { bits:     "2"
          name:     "PSS"
          desc:     "PortSuspendStatus"
          swaccess: "rw"
          hwaccess: "hrw"
          resval:   "0"
        }
        { bits:     "1"
          name:     "PES"
          desc:     "PortEnableStatus"
          swaccess: "rw"
          hwaccess: "hrw"
          resval:   "0"
        }
        { bits:     "0"
          name:     "CCS"
          desc:     "CurrentConnectStatus"
          swaccess: "rw"
          hwaccess: "hrw"
          resval:   "0"
        }
      ]
    }


    

  ]
}
