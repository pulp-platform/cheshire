// Copyright 2022 ETH Zurich and University of Bologna.
// Solderpad Hardware License, Version 0.51, see LICENSE for details.
// SPDX-License-Identifier: SHL-0.51
// Licensed under Solderpad Hardware License, Version 0.51, see LICENSE for details.
//
// Nicole Narr <narrn@student.ethz.ch>
// Christopher Reinwardt <creinwar@student.ethz.ch>
// Paul Scheffler <paulsc@iis.ee.ethz.ch>

{
  name: "cheshire"
  clock_primary: "clk_i"
  bus_interfaces: [
    { protocol: "reg_iface", direction: "device" }
  ],
  regwidth: 32
  registers: [

    { multireg:
      { name:     "scratch"
        desc:     "Registers for use by software"
        swaccess: "rw"
        hwaccess: "none"
        count:    "4"
        cname:    "scratch"
        fields: [
          { bits: "31:0", resval: "0", name: "scratch", desc: "Registers for use by software" }
        ]
      }
    }

    { name:     "boot_mode"
      desc:     "Method to load boot code (connected to input pins)"
      swaccess: "ro"
      hwaccess: "hwo"
      hwqe:     "true"
      hwext:    "true"
      fields: [
        { bits: "1:0"
          name: "boot_mode"
          desc: "Method to load boot code (connected to input pins)"
          enum: [
            { value: "0", name: "passive",       desc: "Wait for external preload and launch"  }
            { value: "1", name: "spi_sdcard",    desc: "Boot from SD Card in SPI mode"         }
            { value: "2", name: "spi_s25fs512s", desc: "Boot from S25FS512S SPI NOR flash"     }
            { value: "3", name: "i2c_24xx1025",  desc: "Boot from 24xx1025 I2C EEPROM"         }
          ]
        }
      ]
    }

    { name:     "rtc_freq"
      desc:     "Frequency (Hz) configured for RTC"
      swaccess: "ro"
      hwaccess: "hwo"
      hwqe:     "true"
      hwext:    "true"
      fields: [
        { bits: "31:0", name: "ref_freq", desc: "Frequency (Hz) configured for RTC" }
      ]
    }

    { name:     "platform_rom"
      desc:     "Address of platform ROM"
      swaccess: "ro"
      hwaccess: "hwo"
      hwqe:     "true"
      hwext:    "true"
      fields: [
        { bits: "31:0", name: "platform_rom", desc: "Address of platform ROM" }
      ]
    }

    { name:     "hw_features"
      desc:     "Specifies which hardware features are available"
      swaccess: "ro"
      hwaccess: "hwo"
      hwqe:     "true"
      hwext:    "true"
      fields: [
        { bits: "0",  name: "bootrom",      desc: "Whether boot ROM is available"     }
        { bits: "1",  name: "llc",          desc: "Whether LLC is available"          }
        { bits: "2",  name: "uart",         desc: "Whether UART is available"         }
        { bits: "3",  name: "spi_host",     desc: "Whether SPI host is available"     }
        { bits: "4",  name: "i2c",          desc: "Whether I2C is available"          }
        { bits: "5",  name: "gpio",         desc: "Whether I2C is available"          }
        { bits: "6",  name: "dma",          desc: "Whether DMA is available"          }
        { bits: "7",  name: "serial_link",  desc: "Whether serial link is available"  }
        { bits: "8",  name: "vga",          desc: "Whether VGA is available"          }

      ]
    }

    { name:     "llc_size"
      desc:     "Total size of LLC in bytes"
      swaccess: "ro"
      hwaccess: "hwo"
      hwqe:     "true"
      hwext:    "true"
      fields: [
        { bits: "31:0", name: "llc_size", desc: "Total size of LLC in bytes" }

      ]
    }

    { name:     "vga_params"
      desc:     "VGA hardware parameters"
      swaccess: "ro"
      hwaccess: "hwo"
      hwqe:     "true"
      hwext:    "true"
      fields: [
        { bits: "7:0",    name: "red_width",    desc: "Red channel width"   }
        { bits: "15:8",   name: "green_width",  desc: "Green channel width" }
        { bits: "23:16",  name: "blue_width",   desc: "Blue channel width"  }

      ]
    }

  ]
}
