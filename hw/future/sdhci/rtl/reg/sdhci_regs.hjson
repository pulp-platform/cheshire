{
  #"human_name": SD Host Controller ver1.00 Registers
  name: "sdhci"
  clock_primary: "clk_i"
  reset_primary: "rst_ni"
  bus_interfaces: [
    {
      protocol: "reg_iface"
      direction: "device"
    }
  ]
  regwidth: 32
  interrupt_list: []
  registers: [
    {
      name: "system_address"
      desc: ""
      hwaccess: "hrw"
      fields: [
        {
          bits: "31:0"
          name: "dma_system_address"
          desc: ""
          swaccess: "rw"
        }
      ]
    }
    {
      packed: [
        {
          name: "block_size"
          desc: ""
          hwaccess: "hrw"
          fields: [
            {
              bits: "15"
              name: "rsvd_15"
              desc: ""
              swaccess: "ro"
              hwaccess: "none"
              resval: "0"
            }
            {
              bits: "14:12"
              name: "host_dma_buffer_boundary"
              desc: ""
              swaccess: "rw"
            }
            {
              bits: "11:0"
              name: "transfer_block_size"
              desc: ""
              swaccess: "rw"
            }
          ]
        }
        {
          name: "block_count"
          desc: ""
          hwaccess: "hrw"
          fields: [
            {
              bits: "15:0"
              name: "blocks_count_for_current_transfer"
              desc: ""
              swaccess: "rw"
            }
          ]
        }
      ]
    }
    {
      name: "argument"
      desc: ""
      hwaccess: "hrw"
      fields: [
        {
          bits: "31:0"
          name: "command_argument"
          desc: ""
          swaccess: "rw"
        }
      ]
    }
    {
      packed: [
        {
          name: "transfer_mode"
          desc: ""
          hwaccess: "hrw"
          fields: [
            {
              bits: "15:8"
              name: "rsvd_8"
              desc: ""
              swaccess: "ro"
              hwaccess: "none"
              resval: "0"
            }
            {
              bits: "7:6"
              name: "rsvd_6"
              desc: ""
              swaccess: "ro"
              hwaccess: "none"
              resval: "0"
            }
            {
              bits: "5"
              name: "multi_single_block_select"
              desc: ""
              swaccess: "rw"
            }
            {
              bits: "4"
              name: "data_transfer_direction_select"
              desc: ""
              swaccess: "rw"
            }
            {
              bits: "3"
              name: "rsvd_3"
              desc: ""
              swaccess: "ro"
              hwaccess: "none"
              resval: "0"
            }
            {
              bits: "2"
              name: "auto_cmd12_enable"
              desc: ""
              swaccess: "rw"
            }
            {
              bits: "1"
              name: "block_count_enable"
              desc: ""
              swaccess: "rw"
            }
            {
              bits: "0"
              name: "dma_enable"
              desc: ""
              swaccess: "rw"
            }
          ]
        }
        {
          name: "command"
          desc: ""
          hwaccess: "hrw"
          hwqe: true
          fields: [
            {
              bits: "15:14"
              name: "rsvd_14"
              desc: ""
              swaccess: "ro"
              hwaccess: "none"
              resval: "0"
            }
            {
              bits: "13:8"
              name: "command_index"
              desc: ""
              swaccess: "rw"
            }
            {
              bits: "7:6"
              name: "command_type"
              desc: ""
              swaccess: "rw"
            }
            {
              bits: "5"
              name: "data_present_select"
              desc: ""
              swaccess: "rw"
            }
            {
              bits: "4"
              name: "command_index_check_enable"
              desc: ""
              swaccess: "rw"
            }
            {
              bits: "3"
              name: "command_crc_check_enable"
              desc: ""
              swaccess: "rw"
            }
            {
              bits: "2"
              name: "rsvd_2"
              desc: ""
              swaccess: "ro"
              hwaccess: "none"
              resval: "0"
            }
            {
              bits: "1:0"
              name: "response_type_select"
              desc: ""
              swaccess: "rw"
            }
          ]
        }
      ]
    }
    {
      name: "response0"
      desc: ""
      hwaccess: "hrw"
      // "hwqe": true
      fields: [
        {
          bits: "31:0"
          name: "response"
          desc: ""
          swaccess: "ro"
          resval: "0"
        }
      ]
    }
    {
      name: "response1"
      desc: ""
      hwaccess: "hrw"
      fields: [
        {
          bits: "31:0"
          name: "response"
          desc: ""
          swaccess: "ro"
          resval: "0"
        }
      ]
    }
    {
      name: "response2"
      desc: ""
      hwaccess: "hrw"
      fields: [
        {
          bits: "31:0"
          name: "response"
          desc: ""
          swaccess: "ro"
          resval: "0"
        }
      ]
    }
    {
      name: "response3"
      desc: ""
      hwaccess: "hrw"
      fields: [
        {
          bits: "31:0"
          name: "response"
          desc: ""
          swaccess: "ro"
          resval: "0"
        }
      ]
    }
    {
      name: "buffer_data_port"
      desc: ""
      hwext: true
      hwqe: true
      hwre: true
      swaccess: "rw"
      hwaccess: "hrw"
      fields: [
        {
          bits: "31:0"
          name: "buffer_data"
          desc: ""
        }
      ]
    }
    {
      name: "present_state"
      desc: ""
      swaccess: "ro"
      hwaccess: "hrw"
      fields: [
        {
          bits: "15:12"
          name: "rsvd_12"
          desc: ""
          swaccess: "ro"
          hwaccess: "none"
          resval: "0"
        }
        {
          bits: "11"
          name: "buffer_read_enable"
          desc: ""
          resval: "0"
        }
        {
          bits: "10"
          name: "buffer_write_enable"
          desc: ""
          resval: "0"
        }
        {
          bits: "9"
          name: "read_transfer_active"
          desc: ""
          resval: "0"
        }
        {
          bits: "8"
          name: "write_transfer_active"
          desc: ""
          resval: "0"
        }
        {
          bits: "7:3"
          name: "rsvd_3"
          desc: ""
          swaccess: "ro"
          hwaccess: "none"
          resval: "0"
        }
        {
          bits: "2"
          name: "dat_line_active"
          desc: ""
          resval: "0"
        }
        {
          bits: "1"
          name: "command_inhibit_dat"
          desc: ""
          resval: "0"
        }
        {
          bits: "0"
          name: "command_inhibit_cmd"
          desc: ""
          resval: "0"
        }
        {
          bits: "31:25"
          name: "rsvd_25"
          desc: ""
          swaccess: "ro"
          hwaccess: "none"
          resval: "0"
        }
        {
          bits: "24"
          name: "cmd_line_signal_level"
          desc: ""
          resval: "0"
        }
        {
          bits: "23:20"
          name: "dat_line_signal_level"
          desc: ""
          resval: "0"
        }
        {
          bits: "19"
          name: "write_protect_switch_pin_level"
          desc: ""
          resval: "0"
        }
        {
          bits: "18"
          name: "card_detect_pin_level"
          desc: ""
          resval: "0"
        }
        {
          bits: "17"
          name: "card_state_stable"
          desc: ""
          resval: "0"
        }
        {
          bits: "16"
          name: "card_inserted"
          desc: ""
          resval: "0"
        }
      ]
    }
    {
      packed: [
        {
          name: "host_control"
          desc: ""
          swaccess: "rw"
          hwaccess: "hrw"
          fields: [
            {
              bits: "7:3"
              name: "rsvd_3"
              desc: ""
              swaccess: "ro"
              hwaccess: "none"
              resval: "0"
            }
            {
              bits: "2"
              name: "high_speed_enable"
              desc: ""
            }
            {
              bits: "1"
              name: "data_transfer_width"
              desc: ""
              resval: "0"
            }
            {
              bits: "0"
              name: "led_control"
              desc: ""
            }
          ]
        }
        {
          name: "power_control"
          desc: ""
          swaccess: "rw"
          hwaccess: "hrw"
          fields: [
            {
              bits: "7:4"
              name: "rsvd_4"
              desc: ""
              swaccess: "ro"
              hwaccess: "none"
              resval: "0"
            }
            {
              bits: "3:1"
              name: "sd_bus_voltage_select"
              desc: ""
            }
            {
              bits: "0"
              name: "sd_bus_power"
              desc: ""
            }
          ]
        }
        {
          name: "block_gap_control"
          desc: ""
          hwaccess: "hrw"
          fields: [
            {
              bits: "7:4"
              name: "rsvd_4"
              desc: ""
              swaccess: "ro"
              hwaccess: "none"
              resval: "0"
            }
            {
              bits: "3"
              name: "interrupt_at_block_gap"
              desc: ""
              swaccess: "rw"
            }
            {
              bits: "2"
              name: "read_wait_control"
              desc: ""
              swaccess: "rw"
            }
            {
              bits: "1"
              name: "continue_request"
              desc: ""
              swaccess: "rw1s"
            }
            {
              bits: "0"
              name: "stop_at_block_gap_request"
              desc: ""
              swaccess: "rw"
            }
          ]
        }
        {
          name: "wakeup_control"
          desc: ""
          swaccess: "rw"
          hwaccess: "hrw"
          fields: [
            {
              bits: "7:3"
              name: "rsvd_3"
              desc: ""
              swaccess: "ro"
              hwaccess: "none"
              resval: "0"
            }
            {
              bits: "2"
              name: "wakeup_event_enable_on_sd_card_removal"
              desc: ""
              swaccess: "rw"
            }
            {
              bits: "1"
              name: "wakeup_event_enable_on_sd_card_insertion"
              desc: ""
              swaccess: "rw"
            }
            {
              bits: "0"
              name: "wakeup_event_enable_on_card_interrupt"
              desc: ""
              swaccess: "rw"
            }
          ]
        }
      ]
    }
    {
      packed: [
        {
          name: "clock_control"
          desc: ""
          hwaccess: "hrw"
          hwqe: true
          fields: [
            {
              bits: "15:8"
              name: "sdclk_frequency_select"
              desc: ""
              swaccess: "rw"
            }
            {
              bits: "7:3"
              name: "rsvd_3"
              desc: ""
              swaccess: "ro"
              hwaccess: "none"
              resval: "0"
            }
            {
              bits: "2"
              name: "sd_clock_enable"
              desc: ""
              swaccess: "rw"
            }
            {
              bits: "1"
              name: "internal_clock_stable"
              desc: ""
              swaccess: "ro"
              resval: "1"
            }
            {
              bits: "0"
              name: "internal_clock_enable"
              desc: ""
              swaccess: "rw"
            }
          ]
        }
        {
          name: "timeout_control"
          desc: ""
          hwaccess: "hrw"
          fields: [
            {
              bits: "7:4"
              name: "rsvd_4"
              desc: ""
              swaccess: "ro"
              hwaccess: "none"
              resval: "0"
            }
            {
              bits: "3:0"
              name: "data_timeout_counter_value"
              desc: ""
              swaccess: "rw"
            }
          ]
        }
        {
          name: "software_reset"
          desc: ""
          hwaccess: "hrw"
          fields: [
            {
              bits: "7:4"
              name: "rsvd_4"
              desc: ""
              swaccess: "ro"
              hwaccess: "none"
              resval: "0"
            }
            {
              bits: "2"
              name: "software_reset_for_dat_line"
              desc: ""
              swaccess: "rw1s"
            }
            {
              bits: "1"
              name: "software_reset_for_cmd_line"
              desc: ""
              swaccess: "rw1s"
            }
            {
              bits: "0"
              name: "software_reset_for_all"
              desc: ""
              swaccess: "rw1s"
            }
          ]
        }
      ]
    }
    {
      packed: [
        {
          name: "normal_interrupt_status"
          desc: ""
          hwaccess: "hrw"
          fields: [
            {
              bits: "15"
              name: "error_interrupt"
              desc: ""
              swaccess: "ro"
              resval: "0"
            }
            {
              bits: "14:9"
              name: "rsvd_9"
              desc: ""
              swaccess: "ro"
              hwaccess: "none"
              resval: "0"
            }
            {
              bits: "8"
              name: "card_interrupt"
              desc: ""
              swaccess: "ro"
              resval: "0"
            }
            {
              bits: "7"
              name: "card_removal"
              desc: ""
              swaccess: "rw1c"
            }
            {
              bits: "6"
              name: "card_insertion"
              desc: ""
              swaccess: "rw1c"
            }
            {
              bits: "5"
              name: "buffer_read_ready"
              desc: ""
              swaccess: "rw1c"
            }
            {
              bits: "4"
              name: "buffer_write_ready"
              desc: ""
              swaccess: "rw1c"
            }
            {
              bits: "3"
              name: "dma_interrupt"
              desc: ""
              swaccess: "rw1c"
            }
            {
              bits: "2"
              name: "block_gap_event"
              desc: ""
              swaccess: "rw1c"
            }
            {
              bits: "1"
              name: "transfer_complete"
              desc: ""
              swaccess: "rw1c"
            }
            {
              bits: "0"
              name: "command_complete"
              desc: ""
              swaccess: "rw1c"
            }
          ]
        }
        {
          name: "error_interrupt_status"
          desc: ""
          swaccess: "rw1c"
          hwaccess: "hrw"
          fields: [
            {
              bits: "15:12"
              name: "vendor_specific_error"
              desc: ""
            }
            {
              bits: "11:9"
              name: "rsvd_9"
              desc: ""
              swaccess: "ro"
              hwaccess: "none"
              resval: "0"
            }
            {
              bits: "8"
              name: "auto_cmd12_error"
              desc: ""
            }
            {
              bits: "7"
              name: "current_limit_error"
              desc: ""
            }
            {
              bits: "6"
              name: "data_end_bit_error"
              desc: ""
            }
            {
              bits: "5"
              name: "data_crc_error"
              desc: ""
            }
            {
              bits: "4"
              name: "data_timeout_error"
              desc: ""
            }
            {
              bits: "3"
              name: "command_index_error"
              desc: ""
            }
            {
              bits: "2"
              name: "command_end_bit_error"
              desc: ""
            }
            {
              bits: "1"
              name: "command_crc_error"
              desc: ""
            }
            {
              bits: "0"
              name: "command_timeout_error"
              desc: ""
            }
          ]
        }
      ]
    }
    {
      packed: [
        {
          name: "normal_interrupt_status_enable"
          desc: ""
          hwaccess: "hrw"
          fields: [
            {
              bits: "15"
              name: "fixed_to_0"
              desc: ""
              swaccess: "ro"
              resval: "0"
            }
            {
              bits: "14:9"
              name: "rsvd_9"
              desc: ""
              swaccess: "ro"
              hwaccess: "none"
              resval: "0"
            }
            {
              bits: "8"
              name: "card_interrupt_status_enable"
              desc: ""
              swaccess: "rw"
            }
            {
              bits: "7"
              name: "card_removal_status_enable"
              desc: ""
              swaccess: "rw"
            }
            {
              bits: "6"
              name: "card_insertion_status_enable"
              desc: ""
              swaccess: "rw"
            }
            {
              bits: "5"
              name: "buffer_read_ready_status_enable"
              desc: ""
              swaccess: "rw"
            }
            {
              bits: "4"
              name: "buffer_write_ready_status_enable"
              desc: ""
              swaccess: "rw"
            }
            {
              bits: "3"
              name: "dma_interrupt_status_enable"
              desc: ""
              swaccess: "rw"
            }
            {
              bits: "2"
              name: "block_gap_event_status_enable"
              desc: ""
              swaccess: "rw"
            }
            {
              bits: "1"
              name: "transfer_complete_status_enable"
              desc: ""
              swaccess: "rw"
            }
            {
              bits: "0"
              name: "command_complete_status_enable"
              desc: ""
              swaccess: "rw"
            }
          ]
        }
        {
          name: "error_interrupt_status_enable"
          desc: ""
          swaccess: "rw"
          hwaccess: "hrw"
          fields: [
            {
              bits: "15:12"
              name: "vendor_specific_error_status_enable"
              desc: ""
            }
            {
              bits: "11:9"
              name: "rsvd_9"
              desc: ""
              swaccess: "ro"
              hwaccess: "none"
              resval: "0"
            }
            {
              bits: "8"
              name: "auto_cmd12_error_status_enable"
              desc: ""
            }
            {
              bits: "7"
              name: "current_limit_error_status_enable"
              desc: ""
            }
            {
              bits: "6"
              name: "data_end_bit_error_status_enable"
              desc: ""
            }
            {
              bits: "5"
              name: "data_crc_error_status_enable"
              desc: ""
            }
            {
              bits: "4"
              name: "data_timeout_error_status_enable"
              desc: ""
            }
            {
              bits: "3"
              name: "command_index_error_status_enable"
              desc: ""
            }
            {
              bits: "2"
              name: "command_end_bit_error_status_enable"
              desc: ""
            }
            {
              bits: "1"
              name: "command_crc_error_status_enable"
              desc: ""
            }
            {
              bits: "0"
              name: "command_timeout_error_status_enable"
              desc: ""
            }
          ]
        }
      ]
    }
    {
      packed: [
        {
          name: "normal_interrupt_signal_enable"
          desc: ""
          hwaccess: "hrw"
          fields: [
            {
              bits: "15"
              name: "fixed_to_0"
              desc: ""
              swaccess: "ro"
              hwaccess: "none"
              resval: "0"
            }
            {
              bits: "14:9"
              name: "rsvd_9"
              desc: ""
              swaccess: "ro"
              hwaccess: "none"
              resval: "0"
            }
            {
              bits: "8"
              name: "card_interrupt_signal_enable"
              desc: ""
              swaccess: "rw"
            }
            {
              bits: "7"
              name: "card_removal_signal_enable"
              desc: ""
              swaccess: "rw"
            }
            {
              bits: "6"
              name: "card_insertion_signal_enable"
              desc: ""
              swaccess: "rw"
            }
            {
              bits: "5"
              name: "buffer_read_ready_signal_enable"
              desc: ""
              swaccess: "rw"
            }
            {
              bits: "4"
              name: "buffer_write_ready_signal_enable"
              desc: ""
              swaccess: "rw"
            }
            {
              bits: "3"
              name: "dma_interrupt_signal_enable"
              desc: ""
              swaccess: "rw"
            }
            {
              bits: "2"
              name: "block_gap_event_signal_enable"
              desc: ""
              swaccess: "rw"
            }
            {
              bits: "1"
              name: "transfer_complete_signal_enable"
              desc: ""
              swaccess: "rw"
            }
            {
              bits: "0"
              name: "command_complete_signal_enable"
              desc: ""
              swaccess: "rw"
            }
          ]
        }
        {
          name: "error_interrupt_signal_enable"
          desc: ""
          swaccess: "rw"
          hwaccess: "hrw"
          fields: [
            {
              bits: "15:12"
              name: "vendor_specific_error_signal_enable"
              desc: ""
            }
            {
              bits: "11:9"
              name: "rsvd_9"
              desc: ""
              swaccess: "ro"
              hwaccess: "none"
              resval: "0"
            }
            {
              bits: "8"
              name: "auto_cmd12_error_signal_enable"
              desc: ""
            }
            {
              bits: "7"
              name: "current_limit_error_signal_enable"
              desc: ""
            }
            {
              bits: "6"
              name: "data_end_bit_error_signal_enable"
              desc: ""
            }
            {
              bits: "5"
              name: "data_crc_error_signal_enable"
              desc: ""
            }
            {
              bits: "4"
              name: "data_timeout_error_signal_enable"
              desc: ""
            }
            {
              bits: "3"
              name: "command_index_error_signal_enable"
              desc: ""
            }
            {
              bits: "2"
              name: "command_end_bit_error_signal_enable"
              desc: ""
            }
            {
              bits: "1"
              name: "command_crc_error_signal_enable"
              desc: ""
            }
            {
              bits: "0"
              name: "command_timeout_error_signal_enable"
              desc: ""
            }
          ]
        }
      ]
    }
    {
      name: "auto_cmd12_error_status"
      desc: ""
      swaccess: "ro"
      resval: "0"
      hwaccess: "hrw"
      fields: [
        {
          bits: "15:8"
          name: "rsvd_8"
          desc: ""
          swaccess: "ro"
          hwaccess: "none"
          resval: "0"
        }
        {
          bits: "7"
          name: "command_not_issued_by_auto_cmd12_error"
          desc: ""
        }
        {
          bits: "6:5"
          name: "rsvd_5"
          desc: ""
          swaccess: "ro"
          hwaccess: "none"
          resval: "0"
        }
        {
          bits: "4"
          name: "auto_cmd12_index_error"
          desc: ""
        }
        {
          bits: "3"
          name: "auto_cmd12_end_bit_error"
          desc: ""
        }
        {
          bits: "2"
          name: "auto_cmd12_crc_error"
          desc: ""
        }
        {
          bits: "1"
          name: "auto_cmd12_timeout_error"
          desc: ""
        }
        {
          bits: "0"
          name: "auto_cmd12_not_executed"
          desc: ""
        }
      ]
    }
    {
      name: "capabilities"
      desc: ""
      swaccess: "ro"
      hwaccess: "hrw"
      fields: [
        {
          bits: "31:27"
          name: "rsvd_27"
          desc: ""
          swaccess: "ro"
          hwaccess: "none"
          resval: "0"
        }
        {
          bits: "26"
          name: "voltage_support_1_8v"
          desc: ""
          resval: "0"
        }
        {
          bits: "25"
          name: "voltage_support_3_0v"
          desc: ""
          resval: "0"
        }
        {
          bits: "24"
          name: "voltage_support_3_3v"
          desc: ""
          resval: "1"
        }
        {
          bits: "23"
          name: "suspend_resume_support"
          desc: ""
          resval: "0"
        }
        {
          bits: "22"
          name: "dma_support"
          desc: ""
          resval: "0"
        }
        {
          bits: "21"
          name: "high_speed_support"
          desc: ""
          resval: "0"
        }
        {
          bits: "20:18"
          name: "rsvd_18"
          desc: ""
          swaccess: "ro"
          hwaccess: "none"
          resval: "0"
        }
        {
          bits: "17:16"
          name: "max_block_length"
          desc: ""
          resval: "0b00" // 512
        }
        {
          bits: "15:14"
          name: "rsvd_14"
          desc: ""
          swaccess: "ro"
          hwaccess: "none"
          resval: "0"
        }
        {
          bits: "13:8"
          name: "base_clock_frequency_for_sd_clock"
          desc: ""
          resval: "0b011001" // 25Mhz
        }
        {
          bits: "7"
          name: "timeout_clock_unit"
          desc: ""
          resval: "1" // MHz
        }
        {
          bits: "6"
          name: "rsvd_6"
          desc: ""
          swaccess: "ro"
          hwaccess: "none"
          resval: "0"
        }
        {
          bits: "5:0"
          name: "timeout_clock_frequency"
          desc: ""
          resval: "0b011001" // 25Mhz
        }
      ]
    }
    // Capabilities (Reserved)
    {
      name: "capabilities_reserved"
      desc: ""
      fields: [
        {
          bits: "31:0"
          name: "rsvd"
          desc: ""
          swaccess: "ro"
          hwaccess: "none"
          resval: "0"
        }
      ]
    }
    {
      name: "maximum_current_capabilities"
      desc: ""
      swaccess: "ro"
      hwaccess: "hro"
      fields: [
        {
          bits: "31:24"
          name: "rsvd_24"
          desc: ""
          swaccess: "ro"
          hwaccess: "none"
          resval: "0"
        }
        {
          bits: "23:16"
          name: "maximum_current_for_1_8v"
          desc: ""
        }
        {
          bits: "15:8"
          name: "maximum_current_for_3_0v"
          desc: ""
        }
        {
          bits: "7:0"
          name: "maximum_current_for_3_3v"
          desc: ""
        }
      ]
    }
    // Maximum Current Capabilities (Reserved)
    {
      name: "maximum_current_capabilities_reserved"
      desc: ""
      fields: [
        {
          bits: "31:0"
          name: "rsvd"
          desc: ""
          swaccess: "ro"
          hwaccess: "none"
          resval: "0"
        }
      ]
    }


    // Unused
    {
      reserved: 41
    }

    // Shared Registry Area
    {
      reserved: 2
    }
    {
      packed: [
        {
          name: "slot_interrupt_status_register"
          desc: ""
          swaccess: "ro"
          resval: "0"
          hwaccess: "hrw"
          fields: [
            {
              bits: "15:8"
              name: "rsvd_8"
              desc: ""
              swaccess: "ro"
              hwaccess: "none"
              resval: "0"
            }
            {
              bits: "7:0"
              name: "interrupt_signal_for_each_slot"
              desc: ""
            }
          ]
        }
        {
          name: "host_controller_version_register"
          desc: ""
          swaccess: "ro"
          hwaccess: "hrw"
          fields: [
            {
              bits: "15:8"
              name: "vendor_version_number"
              desc: ""
              resval: "0"
            }
            {
              bits: "7:0"
              name: "specification_version_number"
              desc: ""
              resval: "0"
            }
          ]
        }
      ]
    }
  ]
}