// Copyright 2022 ETH Zurich and University of Bologna.
// Solderpad Hardware License, Version 0.51, see LICENSE for details.
// SPDX-License-Identifier: SHL-0.51
// Licensed under Solderpad Hardware License, Version 0.51, see LICENSE for details.
//
// Nicole Narr <narrn@student.ethz.ch>
// Christopher Reinwardt <creinwar@student.ethz.ch>
// Paul Scheffler <paulsc@iis.ee.ethz.ch>

{
  name: "chs_xilinx"
  clock_primary: "clk_i"
  bus_interfaces: [
    { protocol: "reg_iface", direction: "device" }
  ],
  regwidth: 32
  registers: [

    { name:     "fan_ctl"
      desc:     "PWM Setting"
      swaccess: "rw"
      hwaccess: "hrw"
      fields: [
        { bits: "3:0", name: "fan_ctl", desc: "PWM Setting" }
      ]
    },
    { name:     "fan_sw_override"
      desc:     "Override Fan Switches"
      swaccess: "rw"
      hwaccess: "hro"
      fields: [
        { bits: "0:0", name: "fan_sw_override", desc: "Override Fan Switches" }
      ]
    },
    { name:     "ram_aw_delay"
      desc:     "AW Delay DRAM"
      swaccess: "rw"
      hwaccess: "hro"
      fields: [
        { bits: "15:0", name: "fan_ctl", desc: "AW Delay DRAM" }
      ]
    },
    { name:     "ram_w_delay"
      desc:     "W Delay DRAM"
      swaccess: "rw"
      hwaccess: "hro"
      fields: [
        { bits: "15:0", name: "fan_ctl", desc: "W Delay DRAM" }
      ]
    },
    { name:     "ram_b_delay"
      desc:     "B Delay DRAM"
      swaccess: "rw"
      hwaccess: "hro"
      fields: [
        { bits: "15:0", name: "fan_ctl", desc: "B Delay DRAM" }
      ]
    },
    { name:     "ram_ar_delay"
      desc:     "AR Delay DRAM"
      swaccess: "rw"
      hwaccess: "hro"
      fields: [
        { bits: "15:0", name: "fan_ctl", desc: "AR Delay DRAM" }
      ]
    },
    { name:     "ram_r_delay"
      desc:     "R Delay DRAM"
      swaccess: "rw"
      hwaccess: "hro"
      fields: [
        { bits: "15:0", name: "fan_ctl", desc: "R Delay DRAM" }
      ]
    }
  ]
}
